simulator lang=spectre

* Minimal example: Subcircuit definition
subckt inverter in out vdd vss
    parameters w=1.0u l=0.18u
ends inverter
